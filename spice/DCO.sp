**********************************************
* Advanced Digital IC Design (U18)           *
*                                            *
* DCO U18                                    *
**********************************************

**********************************************
* Parameters                                 *
**********************************************
** Voltage: 1.8V **
.PARAM supply=1.8v

** Temperature: 25C **
.PARAM temperature=25
.TEMP temperature

**********************************************
* Define Global Nets                         *
**********************************************
.GLOBAL VDD VSS

**********************************************
* Voltage Sources                            *
**********************************************
vdd VDD 0 DC supply
vss VSS 0 DC 0

**********************************************
* subcircuit setup                           *
**********************************************
.INCLUDE "ultrasim_cells.sp"

**********************************************
* Subckt Definition                          *
**********************************************

.SUBCKT DCO
+ RESET_ DCO_CODE_0 DCO_CODE_1 DCO_CODE_2 DCO_CODE_3 DCO_CODE_4 DCO_CODE_5 DCO_CODE_6
+ DCO_OUT
X1_tBUF0 VDD DCO_OUT C0 TBUFX1
X2_tBUF0 VDD C0 C1 TBUFX1
X3_tBUF0 VDD C1 C2 TBUFX1

X1_nand1 RESET_ C2 DCO_OUT NAND2X1
X1_nand2 RESET_ C2 DCO_OUT NAND2X1
X1_nand3 RESET_ C2 DCO_OUT NAND2X1
X1_nand4 RESET_ C2 DCO_OUT NAND2X1
X1_nand5 RESET_ C2 DCO_OUT NAND2X1
X1_nand6 RESET_ C2 DCO_OUT NAND2X1

**first level
X1_tBUF1 DCO_CODE_0 DCO_OUT C0 TBUFX1
X1_tBUF2 DCO_CODE_2 DCO_OUT C0 TBUFX1
X1_tBUF3 DCO_CODE_3 DCO_OUT C0 TBUFX1
X1_tBUF4 DCO_CODE_3 DCO_OUT C0 TBUFX1
X1_tBUF5 DCO_CODE_3 DCO_OUT C0 TBUFX1
X1_tBUF6 DCO_CODE_4 DCO_OUT C0 TBUFX1
X1_tBUF7 DCO_CODE_4 DCO_OUT C0 TBUFX1
X1_tBUF8 DCO_CODE_4 DCO_OUT C0 TBUFX1
X1_tBUF9 DCO_CODE_4 DCO_OUT C0 TBUFX1
X1_tBUF10 DCO_CODE_4 DCO_OUT C0 TBUFX1

X1_tBUF11 DCO_CODE_4 DCO_OUT C0 TBUFX1
X1_tBUF12 DCO_CODE_5 DCO_OUT C0 TBUFX1
X1_tBUF13 DCO_CODE_5 DCO_OUT C0 TBUFX1
X1_tBUF14 DCO_CODE_5 DCO_OUT C0 TBUFX1
X1_tBUF15 DCO_CODE_5 DCO_OUT C0 TBUFX1
X1_tBUF16 DCO_CODE_5 DCO_OUT C0 TBUFX1
X1_tBUF17 DCO_CODE_5 DCO_OUT C0 TBUFX1
X1_tBUF18 DCO_CODE_5 DCO_OUT C0 TBUFX1
X1_tBUF19 DCO_CODE_5 DCO_OUT C0 TBUFX1
X1_tBUF20 DCO_CODE_5 DCO_OUT C0 TBUFX1

X1_tBUF21 DCO_CODE_6 DCO_OUT C0 TBUFX1
X1_tBUF22 DCO_CODE_6 DCO_OUT C0 TBUFX1
X1_tBUF23 DCO_CODE_6 DCO_OUT C0 TBUFX1
X1_tBUF24 DCO_CODE_6 DCO_OUT C0 TBUFX1
X1_tBUF25 DCO_CODE_6 DCO_OUT C0 TBUFX1
X1_tBUF26 DCO_CODE_6 DCO_OUT C0 TBUFX1
X1_tBUF27 DCO_CODE_6 DCO_OUT C0 TBUFX1
X1_tBUF28 DCO_CODE_6 DCO_OUT C0 TBUFX1
X1_tBUF29 DCO_CODE_6 DCO_OUT C0 TBUFX1
X1_tBUF30 DCO_CODE_6 DCO_OUT C0 TBUFX1

X1_tBUF31 DCO_CODE_6 DCO_OUT C0 TBUFX1
X1_tBUF32 DCO_CODE_6 DCO_OUT C0 TBUFX1
X1_tBUF33 DCO_CODE_6 DCO_OUT C0 TBUFX1
X1_tBUF34 DCO_CODE_6 DCO_OUT C0 TBUFX1
X1_tBUF35 DCO_CODE_6 DCO_OUT C0 TBUFX1
X1_tBUF36 DCO_CODE_6 DCO_OUT C0 TBUFX1
X1_tBUF37 DCO_CODE_6 DCO_OUT C0 TBUFX1
X1_tBUF38 DCO_CODE_6 DCO_OUT C0 TBUFX1
X1_tBUF39 DCO_CODE_6 DCO_OUT C0 TBUFX1
X1_tBUF40 DCO_CODE_6 DCO_OUT C0 TBUFX1
X1_tBUF41 DCO_CODE_6 DCO_OUT C0 TBUFX1
X1_tBUF42 DCO_CODE_6 DCO_OUT C0 TBUFX1
X1_tBUF43 DCO_CODE_6 DCO_OUT C0 TBUFX1

**second level
X2_tBUF1 DCO_CODE_1 C0 C1 TBUFX1
X2_tBUF2 DCO_CODE_2 C0 C1 TBUFX1
X2_tBUF3 DCO_CODE_3 C0 C1 TBUFX1
X2_tBUF4 DCO_CODE_3 C0 C1 TBUFX1
X2_tBUF5 DCO_CODE_3 C0 C1 TBUFX1
X2_tBUF6 DCO_CODE_4 C0 C1 TBUFX1
X2_tBUF7 DCO_CODE_4 C0 C1 TBUFX1
X2_tBUF8 DCO_CODE_4 C0 C1 TBUFX1
X2_tBUF9 DCO_CODE_4 C0 C1 TBUFX1
X2_tBUF10 DCO_CODE_4 C0 C1 TBUFX1

X2_tBUF11 DCO_CODE_5 C0 C1 TBUFX1
X2_tBUF12 DCO_CODE_5 C0 C1 TBUFX1
X2_tBUF13 DCO_CODE_5 C0 C1 TBUFX1
X2_tBUF14 DCO_CODE_5 C0 C1 TBUFX1
X2_tBUF15 DCO_CODE_5 C0 C1 TBUFX1
X2_tBUF16 DCO_CODE_5 C0 C1 TBUFX1
X2_tBUF17 DCO_CODE_5 C0 C1 TBUFX1
X2_tBUF18 DCO_CODE_5 C0 C1 TBUFX1
X2_tBUF19 DCO_CODE_5 C0 C1 TBUFX1
X2_tBUF20 DCO_CODE_5 C0 C1 TBUFX1
X2_tBUF21 DCO_CODE_6 C0 C1 TBUFX1
X2_tBUF22 DCO_CODE_6 C0 C1 TBUFX1
X2_tBUF23 DCO_CODE_6 C0 C1 TBUFX1
X2_tBUF24 DCO_CODE_6 C0 C1 TBUFX1
X2_tBUF25 DCO_CODE_6 C0 C1 TBUFX1
X2_tBUF26 DCO_CODE_6 C0 C1 TBUFX1
X2_tBUF27 DCO_CODE_6 C0 C1 TBUFX1
X2_tBUF28 DCO_CODE_6 C0 C1 TBUFX1
X2_tBUF29 DCO_CODE_6 C0 C1 TBUFX1
X2_tBUF30 DCO_CODE_6 C0 C1 TBUFX1
X2_tBUF31 DCO_CODE_6 C0 C1 TBUFX1
X2_tBUF32 DCO_CODE_6 C0 C1 TBUFX1
X2_tBUF33 DCO_CODE_6 C0 C1 TBUFX1
X2_tBUF34 DCO_CODE_6 C0 C1 TBUFX1
X2_tBUF35 DCO_CODE_6 C0 C1 TBUFX1
X2_tBUF36 DCO_CODE_6 C0 C1 TBUFX1
X2_tBUF37 DCO_CODE_6 C0 C1 TBUFX1
X2_tBUF38 DCO_CODE_6 C0 C1 TBUFX1
X2_tBUF39 DCO_CODE_6 C0 C1 TBUFX1
X2_tBUF40 DCO_CODE_6 C0 C1 TBUFX1
X2_tBUF41 DCO_CODE_6 C0 C1 TBUFX1
X2_tBUF42 DCO_CODE_6 C0 C1 TBUFX1
*X2_tBUF43 DCO_CODE_6 C0 C1 TBUFX1

**third level
X3_tBUF1  DCO_CODE_1 C1 C2 TBUFX1
X3_tBUF2  DCO_CODE_2 C1 C2 TBUFX1
X3_tBUF3  DCO_CODE_3 C1 C2 TBUFX1
X3_tBUF4  DCO_CODE_3 C1 C2 TBUFX1
X3_tBUF5  DCO_CODE_3 C1 C2 TBUFX1
X3_tBUF6  DCO_CODE_4 C1 C2 TBUFX1
X3_tBUF7  DCO_CODE_4 C1 C2 TBUFX1
X3_tBUF8  DCO_CODE_4 C1 C2 TBUFX1
X3_tBUF9  DCO_CODE_4 C1 C2 TBUFX1
X3_tBUF10 DCO_CODE_4 C1 C2 TBUFX1

X3_tBUF11 DCO_CODE_5 C1 C2 TBUFX1
X3_tBUF12 DCO_CODE_5 C1 C2 TBUFX1
X3_tBUF13 DCO_CODE_5 C1 C2 TBUFX1
X3_tBUF14 DCO_CODE_5 C1 C2 TBUFX1
X3_tBUF15 DCO_CODE_5 C1 C2 TBUFX1
X3_tBUF16 DCO_CODE_5 C1 C2 TBUFX1
X3_tBUF17 DCO_CODE_5 C1 C2 TBUFX1
X3_tBUF18 DCO_CODE_5 C1 C2 TBUFX1
X3_tBUF19 DCO_CODE_5 C1 C2 TBUFX1
X3_tBUF20 DCO_CODE_5 C1 C2 TBUFX1
X3_tBUF21 DCO_CODE_6 C1 C2 TBUFX1
X3_tBUF22 DCO_CODE_6 C1 C2 TBUFX1
X3_tBUF23 DCO_CODE_6 C1 C2 TBUFX1
X3_tBUF24 DCO_CODE_6 C1 C2 TBUFX1
X3_tBUF25 DCO_CODE_6 C1 C2 TBUFX1
X3_tBUF26 DCO_CODE_6 C1 C2 TBUFX1
X3_tBUF27 DCO_CODE_6 C1 C2 TBUFX1
X3_tBUF28 DCO_CODE_6 C1 C2 TBUFX1
X3_tBUF29 DCO_CODE_6 C1 C2 TBUFX1
X3_tBUF30 DCO_CODE_6 C1 C2 TBUFX1
X3_tBUF31 DCO_CODE_6 C1 C2 TBUFX1
X3_tBUF32 DCO_CODE_6 C1 C2 TBUFX1
X3_tBUF33 DCO_CODE_6 C1 C2 TBUFX1
X3_tBUF34 DCO_CODE_6 C1 C2 TBUFX1
X3_tBUF35 DCO_CODE_6 C1 C2 TBUFX1
X3_tBUF36 DCO_CODE_6 C1 C2 TBUFX1
X3_tBUF37 DCO_CODE_6 C1 C2 TBUFX1
X3_tBUF38 DCO_CODE_6 C1 C2 TBUFX1
X3_tBUF39 DCO_CODE_6 C1 C2 TBUFX1
X3_tBUF40 DCO_CODE_6 C1 C2 TBUFX1
X3_tBUF41 DCO_CODE_6 C1 C2 TBUFX1
X3_tBUF42 DCO_CODE_6 C1 C2 TBUFX1
*X3_tBUF43 DCO_CODE_6 C1 C2 TBUFX1

.ENDS DCO

**********************************************
* TOP Circuit                                *
**********************************************
*DCO(RESET_, DCO_CODE_0, DCO_CODE_1, DCO_CODE_2, DCO_CODE_3, DCO_CODE_4, DCO_CODE_5, DCO_CODE_6, DCO_OUT)
*XDC01 RESET_ DCO_CODE_0 DCO_CODE_1 DCO_CODE_2 DCO_CODE_3 DCO_CODE_4 DCO_CODE_5 DCO_CODE_6 DCO_OUT DCO

.end
